module driver(mailbox drv2dut, mailbox gen2drv);

  wreal signal_in;

  always begin
    gen2drv.get(signal_in); // Recibir señal del generador
    drv2dut.put(signal_in);  // Enviar señal al DUT
  end

endmodule
