module agent(mailbox gen2drv, mailbox drv2dut, mailbox dut2mon, mailbox mon2chk);

  generator gen_inst(gen2drv);
  driver drv_inst(drv2dut, gen2drv);
  monitor mon_inst(dut2mon, mon2chk);
  checker chk_inst(mon2chk);
  scoreboard sb_inst(chk2sb);

endmodule
