module monitor(mailbox dut2mon, mailbox mon2chk);

  wreal rising_edge;
  wreal falling_edge;
  wreal freq_out;

  always begin
    dut2mon.get({rising_edge, falling_edge, freq_out}); // Recibir señales del DUT
    mon2chk.put({rising_edge, falling_edge, freq_out});  // Enviar señales al checker
  end

endmodule
