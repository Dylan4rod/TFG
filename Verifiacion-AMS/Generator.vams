module generator(mailbox gen2drv);

  wreal signal;
  real amplitude = 1.0;
  real v_value = 0.0;
  integer i;

  // Generación de señal cuadrada
  initial begin
    v_value = 0.0;
    assign_wreal(signal, v_value);

    for (i = 0; i < 20; i = i + 1) begin
      #10;
      v_value = (v_value == 0.0) ? amplitude : 0.0;
      assign_wreal(signal, v_value);
      gen2drv.put(signal); // Enviar señal al driver
    end
  end

endmodule
