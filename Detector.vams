`timescale 1ns/1ps
`include "disciplines.vams"

module detector_flancos_rnm(
  input  wreal a_in,
  output wreal rising_edge,
  output wreal falling_edge
);

  real a_prev;
  real rising_edge_int;
  real falling_edge_int;

  // Lógica de detección de flancos
  always @(a_in) begin
    if ((a_prev < 0.5) && (a_in > 0.5))
      rising_edge_int = 1.0;
    else
      rising_edge_int = 0.0;

    if ((a_prev > 0.5) && (a_in < 0.5))
      falling_edge_int = 1.0;
    else
      falling_edge_int = 0.0;

    a_prev = a_in;
  end

  // Asignación tipo RNM
  assign rising_edge  = rising_edge_int;
  assign falling_edge = falling_edge_int;

endmodule
