timescale Ins/1ps
include "disciplines.h

module detector_flancos_rnm(
  input wreal a in,
  output wreal rising edge,
  output wreal falling edge
);

  real a prev;
  real rising edge int;
  real falling edge int:

// Logica de detección de flancos
always @la in) begin
  if ((a prev 8.5) && (a in 0.5))
    rising edge int 1.0:
  else rising edge int 0.0;

  if (a prev 0.5) 64 (a in < 0.5))
    falling edge int 1.8;
  else falling edge int 0.0;

  a prev a in;
end
// Asignación tipo RNM

assign rising edge assign falling edge rising edge int;
falling edge int;
endnodule
